ADE simulation setup
Run mode: Single Run, Sweeps and Corners
Tests:
  project:ph2_sa_tb_noise:1: project/ph2_sa_tb_prbs/schematic, simulator spectre
Global variables:
  vdd = 1.2
  vin_cm = 0.6
  vamp = 5m
  cff = 5f
  tper = 200p
  tr = 20p
  tsu = 30p
  nfpc = 2
  nfd = 20
  nft = 20
  nfn = 2.5
  nfp = 1.2
  tdelay = tper/2
