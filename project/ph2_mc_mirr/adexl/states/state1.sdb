ADE simulation setup
Run mode: Single Run, Sweeps and Corners
Tests:
  project:ph2_mc:1: project/ph2_mc/schematic, simulator spectre
Global variables:
  ib = 100u
  vg = 0.6
  vgs_start = 1.2
  vgs_stop = 0
