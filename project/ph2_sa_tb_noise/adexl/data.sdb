ADE simulation setup
Run mode: Single Run, Sweeps and Corners
Tests:
  project:ph2_sa_tb_noise:1: project/ph2_sa_tb_noise/schematic, simulator spectre
Global variables:
  vdd = 1.2
  vin_cm = 0.6
  vbig = 0.4
  vamp = {Inclusion List}0.15m 0.2m 0.25m{Inclusion List}
  cff = 5f
  tper = 200p
  tr = 20p
  tsu = 30p
  nfpc = 2
  nfd = 22.8
  nft = 22.8
  nfn = 3
  nfp = 1.2
