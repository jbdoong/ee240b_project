ADE simulation setup
Run mode: Single Run, Sweeps and Corners
Tests:
  project:ph2_sa:1: project/ph2_sa/schematic, simulator spectre
Global variables:
  vdd = 1.2
  vin_cm = 0.6
  vamp = 10m
  cff = 5f
  tper = 200p
  tr = 20p
  tsu = 30p
  nfpc = 2
  nfd = 24
  nft = 24
  nfn = 5
  ratio_pn = 1
  nfp = nfn * ratio_pn
