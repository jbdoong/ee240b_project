ADE simulation setup
Run mode: Single Run, Sweeps and Corners
Tests:
  project:ph3_sa_tb:1: project/ph3_sa_tb/schematic, simulator spectre
Global variables:
  vos1 = 29.16m / sqrt(nfd)
  vos2 = 29.16m / sqrt(nfn)
  vdd = 1.2
  vin_cm = 0.6
  vbig = 0.8
  vamp = 20m
  vin_off = 25m
  cff = 5f
  tper = 120p
  tr = 20p
  tsu = 30p
  nfpc = 4
  nfd = 66
  nft = 66
  nfn = 6
  ratio = 0.4
  nfp = ratio * nfn
