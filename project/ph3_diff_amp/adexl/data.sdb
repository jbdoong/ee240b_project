ADE simulation setup
Run mode: Single Run, Sweeps and Corners
Tests:
  project:ph3_diff_amp:1: project/ph3_diff_amp/schematic, simulator spectre
Global variables:
  vdd = 1.2
  vin_cm = 0.6
  ib = 147.8u
  rl = 2.03k
  cl = 15f
  nf = 91
  nft = 1
