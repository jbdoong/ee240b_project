ADE simulation setup
Run mode: Monte Carlo Sampling
Tests:
  project:ph2_mc_mirr:1: project/ph2_mc_mirr/schematic, simulator spectre
Global variables:
  vg = 0.6
  vg_start = 0
  vg_stop = 1.2
Corners (nominal off):
  model folders: /home/ff/ee240b/sp18/gpdk/gpdk045_v_5_0/models/spectre
  tt (off): temperature=25; gpdk045.scs[tt]
  ff (off): temperature=70; gpdk045.scs[ff]
  ss (off): temperature=0; gpdk045.scs[ss]
  sf (off): temperature=25; gpdk045.scs[sf]
  fs (off): temperature=25; gpdk045.scs[fs]
  Sweep: vg=0.369 0.408 0.441 0.486 0.518 0.557 0.652 0.726  1.010
Monte Carlo Sampling options: mcmethod=all, mcnumpoints=100
